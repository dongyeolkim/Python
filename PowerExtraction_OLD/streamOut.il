streamInKeys = list(nil
    'runDir                 "."
    'inFile                 "mux.gds"
    'primaryCell            "mux"
    'libName                "FULLLIB"
    'techfileName           ""
    'scale                  0.001000
    'units                  "micron"
    'errFile                "./DRC/mux/streamIn.log"
    'refLib                 nil
    'hierDepth              32
    'maxVertices            1024
    'checkPolygon           t
    'snapToGrid             nil
    'arrayToSimMosaic       t
    'caseSensitivity        "preserve"
    'zeroPathToLine         "lines"
    'convertNode            "ignore"
    'keepPcell      nil
    'skipUndefinedLPP       t
    'ignoreBox              nil
    'mergeUndefPurposToDrawing              nil
    'reportPrecision        nil
    'keepStreamCells                nil
    'attachTechfileOfLib            ""
    'runQuiet               nil
    'noWriteExistCell               t
    'NOUnmappingLayerWarning                nil
    'genListHier            nil
    'cellMapTable           ""
    'layerTable             "/softs/dkits/ams/v3.70/artist/HK_H35/TECH_H35B4/strmInOut.layertable"
    'textFontTable          ""
    'restorePin             0
    'propMapTable           ""
    'propSeparator          ","
    'userSkillFile          "/softs/dkits/ams/v3.70/artist/HK_H35/skill/ams_sdl.il"
    'rodDir                 ""
    'refLibOrder                    ""
)
