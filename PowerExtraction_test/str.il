fo.write("streamInKeys = list(nil"\n")
fo.write("    'runDir			".""\n")
fo.write("    'inFile			"HS65_GS_IVX2.gds""\n")
fo.write("    'primaryCell		"HS65_GS_IVX2""\n")
fo.write("    'libName		"TEST""\n")
fo.write("    'viewName		"schematic""\n")
fo.write("    'techfileName		"/home/michel.arendt/work/ascend/st065/layout/cmos065""\n")
fo.write("    'scale			0.100000"\n")
fo.write("    'units			"micron""\n")
fo.write("    'errFile		"PIPO.LOG""\n")
fo.write("    'refLib			"cmos065""\n")
fo.write("    'hierDepth		32"\n")
fo.write("    'maxVertices		1024"\n")
fo.write("    'checkPolygon		t"\n")
fo.write("    'snapToGrid		nil"\n")
fo.write("    'arrayToSimMosaic	t"\n")
fo.write("    'caseSensitivity	"preserve""\n")
fo.write("    'textCaseSensitivity	"preserve""\n")
fo.write("    'zeroPathToLine		"lines""\n")
fo.write("    'convertNode		"ignore""\n")
fo.write("    'keepPcell	nil"\n")
fo.write("    'replaceBusBitChar	nil"\n")
fo.write("    'skipUndefinedLPP	t"\n")
fo.write("    'ignoreBox		nil"\n")
fo.write("    'mergeUndefPurposToDrawing		nil"\n")
fo.write("    'reportPrecision	t"\n")
fo.write("    'keepStreamCells		nil"\n")
fo.write("    'attachTechfileOfLib		"""\n")
fo.write("    'runQuiet		nil"\n")
fo.write("    'noWriteExistCell		nil"\n")
fo.write("    'NOUnmappingLayerWarning		nil"\n")
fo.write("    'comprehensiveLog		nil"\n")
fo.write("    'ignorePcellEvalFail		nil"\n")
fo.write("    'appendDB		nil"\n")
fo.write("    'genListHier		nil"\n")
fo.write("    'skipDbLocking		nil"\n")
fo.write("    'skipPcDbGen		nil"\n")
fo.write("    'cellMapTable		"""\n")
fo.write("    'layerTable		"/soft64/design-kits/stm/65nm-cmos065_536/DK_cmos065lpgp_7m4x0y2z_2V51V8@5.3.6/DATA/LIB/lib/cmos065/cmos065.layermap""\n")
fo.write("    'textFontTable		"""\n")
fo.write("    'restorePin		0"\n")
fo.write("    'propMapTable		"""\n")
fo.write("    'propSeparator		",""\n")
fo.write("    'userSkillFile		"""\n")
fo.write("    'rodDir			"""\n")
fo.write("    'refLibOrder			"cmos065""\n")
fo.write(")"\n")
