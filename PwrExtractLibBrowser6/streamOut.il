streamOutKeys = list(nil
    'runDir                 ""
    'libName                "PCA030S"
    'primaryCell            "PCA030S_TOP"
    'viewName                "layout"
    'outFile                 "/PCA030S_TOP.gds"
    'techfileName           ""
    'scale                  0.001000
    'units                  "micron"
    'errFile                "PIPO.LOG.PCA030S_TOP"
    'libVersion             "5.0"
    'refLib                 nil
    'hierDepth              32
    'maxVertices            1024
    'checkPolygon           t
    'snapToGrid             nil
    'arrayToSimMosaic       t
    'caseSensitivity        "preserve"
    'zeroPathToLine         "lines"
    'convertNode            "ignore"
    'keepPcell      nil
    'skipUndefinedLPP       t
    'ignoreBox              nil
    'mergeUndefPurposToDrawing              nil
    'reportPrecision        nil
    'keepStreamCells                nil
    'attachTechfileOfLib            ""
    'runQuiet               nil
    'noWriteExistCell               t
    'NOUnmappingLayerWarning                nil
    'genListHier            nil
    'cellMapTable           ""
    'layerTable             "strmInOut.layertable"
    'textFontTable          ""
    'restorePin             0
    'propMapTable           ""
    'propSeparator          ","
    'rodDir                 ""
    'refLibOrder                    ""
)
